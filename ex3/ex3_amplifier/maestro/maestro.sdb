ADE simulation setup
Run mode: Single Run, Sweeps and Corners
Tests:
  ex3_ex3_amplifier_1: ex3/ex3_amplifier/schematic, simulator spectre
    Variables: wireopt = 211; W_IN = 130u; L_IN = 200n; W3 = 213.4u
