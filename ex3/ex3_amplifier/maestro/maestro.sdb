ADE simulation setup
Run mode: Single Run, Sweeps and Corners
Tests:
  ex3_ex3_amplifier_1: ex3/ex3_amplifier/schematic, simulator spectre
    Variables: wireopt = 211; VSOURCE_IN = 325m; W_IN = 1m; L_IN = 400n; W3 = 811.6u; L_INCAS = 1u; W_INCAS = 400u; VOUTDC = 0; V_GATE = VIN_DRAIN + VTH_EST + 20e-3; VTH_EST = 253m; VIN_DRAIN = -0.3; VGATE_BIAS = -0.5; W_BIAS = 833.1u; L_BIAS = 5u; FACTOR = 10; L_LOAD = 500n; W_LOAD = 14.25u; L_BA = 10u; L_BB = 25u; W_BA = 1m; W_BB = 846.3u; V_BIASA = -209.48m
