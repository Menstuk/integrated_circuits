ADE simulation setup
Run mode: Single Run, Sweeps and Corners
Tests:
  ex3_ex3_amplifier_1: ex3/ex3_amplifier/schematic, simulator spectre
    Variables: wireopt = 211; W_IN = 820u; L_IN = 500n; W3 = 25.3u; L_INCAS = 500n; W_INCAS = 400u; VOUTDC = 0.3; V_GATE = VIN_DRAIN + VTH_EST + 50e-3; VTH_EST = 285.2m; VIN_DRAIN = 0; VGATE_BIAS = -0.5; W_BIAS = 218.4u; L_BIAS = 1u; LLOAD = 1u; WLOAD = 248.6u; FACTOR = 5
