ADE simulation setup
Run mode: Single Run, Sweeps and Corners
Tests:
  ex3_ex3_amplifier_1: ex3/ex3_amplifier/schematic, simulator spectre
    Variables: CL = 8p; L1 = 400n; W1 = 328u; L2 = 400n; W2 = 6u; L3 = 400n; W3 = 77u; L4 = 400n; W4 = 60u; LIB = 800n; WIB = 4.67u; VDD = 2; VR1 = 1.15; VG2 = 0.8; VG4 = 1.5; VGIB = 1.15; VIN = 1
