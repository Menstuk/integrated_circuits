ADE simulation setup
Run mode: Single Run, Sweeps and Corners
Tests:
  ex3_miller_ota_1: ex3/miller_ota/schematic, simulator spectre
    Variables: wireopt = 211; L6 = 200n; W6 = 166.7u; L_LOAD = 1u; W_LOAD = 168.7u; W_SOURCE = 11.9u; L_SOURCE = 2u; L_IN = 1u; W_IN = 180u; W2 = 165.3u; L2 = 1u; L4 = 3u; W4 = 12.8u; FACTOR = 3; Cc = 300f
    Outputs: /M5/D
