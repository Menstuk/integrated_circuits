ADE simulation setup
Run mode: Single Run, Sweeps and Corners
Tests:
  ex3_miller_ota_1: ex3/miller_ota/schematic, simulator spectre
    Variables: wireopt = 211; L6 = 200n; W6 = 10u:5u:200u; L_LOAD = 1u; W_LOAD = 36.8u; W_SOURCE = 11.6u; L_SOURCE = 2u; L_IN = 1u; W_IN = 171.7u; L4 = 500n; W4 = 13.5u; FACTOR = 1; L4A = 500n; W4A = 4.7u; W_SPECIAL = 0.793u; R = 1k; Cap = 1p; V_trial = 300m; L2 = 1u; W2 = 165.3u
    Outputs: /net20; /net16
