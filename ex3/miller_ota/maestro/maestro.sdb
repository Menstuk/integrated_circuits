ADE simulation setup
Run mode: Single Run, Sweeps and Corners
Tests:
  ex3_miller_ota_1: ex3/miller_ota/schematic, simulator spectre
    Variables: wireopt = 211; L6 = 200n; W6 = 166.7u; L_LOAD = 200n; W_LOAD = 8.92u; W_SOURCE = 11.9u; L_SOURCE = 2u; L_IN = 1u; W_IN = 180u; L4 = 3u; W4 = 12.9u; FACTOR = 3; L4A = 500n; W4A = 4.7u; PHASE = 180; W_SPECIAL = 793n; R = 1k:500:5k; Cap = 800f:400f:4p
    Outputs: /net20; /net16
