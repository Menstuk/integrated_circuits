ADE simulation setup
Run mode: Single Run, Sweeps and Corners
Tests:
  ex3_final_ex_1: ex3/final_ex/schematic, simulator spectre
    Variables: wireopt = 211; VP = 1.1427; N_mult = 60; WN = 400n; LN = 400n; LP = 400n; WP = 400n; WN_BIAS = 800n; CL = 8p; V_ERR = 980m
