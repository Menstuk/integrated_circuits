ADE simulation setup
Run mode: Single Run, Sweeps and Corners
Tests:
  ex3_final_ex_1: ex3/final_ex/schematic, simulator spectre
    Variables: wireopt = 211; LB = 2u; WB = 204n; CL = 8p; MULT1 = 4; W1 = 500u; L1 = 1u; W2 = 41.9u; L2 = 2u; W3 = 48.5u; L3 = 402n; W4 = 310u; L4 = 530n; L0 = 1u; W0 = 643.9u; L5 = 2u; W5 = 435u; L6 = 2u; W6 = 203u; CS = 50p; W7 = 55u; L7 = 2u; W8 = 7.3u; L8 = 1u; vin = 268m; Nfing = 1; L_N1 = 200n; W_N1 = 10u; L_N2 = 3u; W_N2 = 29.7u; L_N3 = 3u; W_N3 = 92.8u; L_N4 = 3u; W_N4 = 3.08435u; L_N5 = 3u; W_N5 = 28.4642u; L_N6 = 1u; W_N6 = 15.7125u; L_N7 = 4u; W_N7 = 3.087u; L_P1 = 1u; W_P1 = 50.6231u; L_P2 = 200n; W_P2 = 124.312u; L_P3 = 200n; W_P3 = 70u; L_P4 = 2u; W_P4 = 2.4026u; L_P5 = 2u; W_P5 = 17.225u; L_P6 = 200n; W_P6 = 0.4u; L_P7 = 6u; W_P7 = 15.772u; Vd11 = 930m; Vs11 = 1.3; Vs33 = 1.6; Rin = 50M; WBIASN = 3u; LB1 = 4u; WB1 = 7.6u; WB2 = 42u; WB3 = 4u; res = 214.3M; LNL = 2u; LPL = 2u; WNL = 59.2u; WPL = 8u; W82 = 142u; WB4 = 300n; VCM = 1; MULT = 1
