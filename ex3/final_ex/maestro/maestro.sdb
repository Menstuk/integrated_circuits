ADE simulation setup
Run mode: Single Run, Sweeps and Corners
Tests:
  ex3_final_ex_1: ex3/final_ex/schematic, simulator spectre
    Variables: wireopt = 211; CL = 8p; W1 = 124u; L1 = 400n; W2 = 11.2116u; L2 = 400n; W3 = 62.899u; L3 = 400n; W4 = 155.616u; L4 = 1u; LIB = 1u; WIB = 614.3u; L5 = 4u; W5 = 341.791u; L6 = 8u; W6 = 37.9u; CS = 100p
