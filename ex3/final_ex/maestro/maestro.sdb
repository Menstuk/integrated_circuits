ADE simulation setup
Run mode: Single Run, Sweeps and Corners
Tests:
  ex3_final_ex_1: ex3/final_ex/schematic, simulator spectre
    Variables: wireopt = 211; CL = 8p; W1 = 600u; L1 = 1u; W2 = 15.468u; L2 = 400n; W3 = 62.899u; L3 = 400n; W4 = 155.616u; L4 = 1u; L0 = 400n; W0 = 474.43u; L5 = 500n; W5 = 31.87u; L6 = 2u; W6 = 40u; CS = 500p; W7 = 20u; L7 = 400n; W8 = 1.926u; L8 = 1u; vin = 100m
    Outputs: /M0/D
