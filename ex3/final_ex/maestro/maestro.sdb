ADE simulation setup
Run mode: Single Run, Sweeps and Corners
Tests:
  ex3_final_ex_1: ex3/final_ex/schematic, simulator spectre
    Variables: wireopt = 211; VDD = 2; CL = 8p; VG2 = 0.8; VG4 = 1.5; VGIB = 1.15; VIN = 1; VR1 = 1.15; W1 = 328u; L1 = 400n; W2 = 6u; L2 = 400n; W3 = 77u; L3 = 400n; W4 = 60u; L4 = 400n; LIB = 800n; WIB = 4.67u
